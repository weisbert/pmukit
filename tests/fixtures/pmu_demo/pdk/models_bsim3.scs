// ============================================================================
// Synthetic BSIM3v3 MOS cards for the pmu_demo fixture.  NOT a real PDK.
//
// Written in SPICE language on purpose: ngspice `level=8` (BSIM3) maps to
// Spectre `level=49`.  Spectre's own level 8 is a generic mos8 and REJECTS a
// BSIM3 card, so `level=49` is the only correct translation.
//
// The cards are the Berkeley BSIM3v3.3 defaults with vth0/tox trimmed for ~1 V
// operation, minus the ngspice-only keys (vgs_max/vds_max/vbs_max) and with the
// NMOS `cdsc` clamped to 0 -- the Berkeley default is a tiny NEGATIVE value that
// Spectre (rightly) warns about on every device instance.
//
// This file is included FROM pdk/toplevel.scs, once per corner section.  The
// including section sets the five corner knobs first; everything else here is
// corner-independent:
//     vthn  vthp   threshold voltages   (V)
//     u0n   u0p    low-field mobility   (cm^2/V/s)
//     toxv         gate oxide thickness (m)
// ============================================================================
simulator lang=spice

.model nlv nmos level=49 version=3.3
+ tnom=27.0
+ nch=2.498e17 tox=toxv xj=1.0e-07
+ lint=9.36e-8 wint=1.47e-7
+ vth0=vthn k1=0.756 k2=-3.83e-2 k3=-2.612 k3b=2.233
+ dvt0=2.812 dvt1=0.462 dvt2=-9.17e-2
+ dvt0w=0 dvt1w=0 dvt2w=0
+ nlx=3.52291e-08 w0=1.163e-6
+ vsat=86301.58 ua=6.47e-9 ub=4.23e-18 uc=-4.706281e-11
+ rdsw=650 u0=u0n wr=1
+ a0=0.3496967 ags=0.1 b0=0.546 b1=1
+ dwg=-6.0e-09 dwb=-3.56e-09 prwb=-0.213 prwg=0
+ keta=-3.605872e-02 a1=2.778747e-02 a2=0.9
+ voff=-6.735529e-02 nfactor=1.139926 cit=1.622527e-04
+ cdsc=0 cdscb=0 cdscd=0
+ eta0=1.0281729e-02 etab=-5.042203e-03 dsub=0.31871233
+ pclm=1.114846 pdiblc1=2.45357e-03 pdiblc2=6.406289e-03 pdiblcb=-0.234
+ drout=0.31871233 pscbe1=5000000 pscbe2=5e-09
+ pvag=0 delta=0.01
+ wl=0 ww=-1.420242e-09 wwl=0 wln=0 wwn=0.2613948
+ ll=1.300902e-10 lw=0 lwl=0 lln=0.316394 lwn=0
+ kt1=-0.3 kt2=-0.051 kt1l=0 ute=-1.48 at=22400 prt=764.3
+ ua1=3.31e-10 ub1=2.61e-19 uc1=-3.42e-10
+ cgso=1.5e-10 cgdo=1.5e-10 cj=1e-3 cjsw=1e-10
+ noimod=1 kf=4e-29 af=1 ef=1

.model plv pmos level=49 version=3.3
+ tnom=27.0
+ nch=3.533024e17 tox=toxv xj=1.0e-07
+ lint=6.23e-8 wint=1.22e-7
+ vth0=vthp k1=0.8362093 k2=-8.606622e-02 k3=1.82 k3b=-0.24
+ dvt0=1.903801 dvt1=0.5333922 dvt2=-0.1862677
+ dvt0w=0.232 dvt1w=4.5e6 dvt2w=-0.0023
+ nlx=1.28e-8 w0=2.1e-6
+ vsat=103503.2 ua=1.39995e-09 ub=1.0e-19 uc=-2.73e-11
+ rdsw=460 u0=u0p prwg=-0.001 prwb=-0.323
+ a0=0.4716551 ags=0.12
+ keta=-1.871516e-03 a1=0.3417965 a2=0.83
+ voff=-0.074182 nfactor=1.54389 cit=-1.015667e-03
+ cdsc=8.937517e-04 cdscb=1.45e-4 cdscd=1.04e-4
+ eta0=6.024776e-02 etab=-4.64593e-03 dsub=0.23222404
+ pclm=0.989 pdiblc1=2.07418e-02 pdiblc2=1.33813e-3
+ drout=0.3222404 pscbe1=118000 pscbe2=1e-09
+ pvag=0
+ kt1=-0.25 kt2=-0.032 kt1l=0 ute=-1.5 at=33000 prt=64.5
+ ua1=4.312e-9 ub1=6.65e-19 uc1=0
+ cgso=1.5e-10 cgdo=1.5e-10 cj=1e-3 cjsw=1e-10
+ noimod=1 kf=4e-29 af=1 ef=1

simulator lang=spectre
