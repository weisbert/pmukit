// ---------------------------------------------------------------------------
// GENERATED by tools/gt_convert.py from ngspice/ldo_classab.lib -- do not hand-edit.
// Synthetic ground-truth circuit; regenerate with `python tools/gt_convert.py`.
// ---------------------------------------------------------------------------
simulator lang=spectre
//  ============================================================
//  Adversarial overfit-probe GT: ldo_classab  (HANDOFF A4)
//    ports: vin vout   (global 0 = gnd)
//    Class-AB PUSH-PULL output stage replacing the single PMOS pass:
//      - PMOS source device  mp : source=vin gate=ng  drain=vout  (sources current)
//      - NMOS sink   device  mn : drain=vout gate=ngn source=gnd   (sinks current)
//    Both conduct at the OP (well-defined gm => small-signal Zout/PSRR/noise
//    are LTI and base-like). On a LARGE sourcing demand the NMOS sink cuts off
//    and the PMOS slams into high-gm sourcing => effective output gm varies
//    strongly over the swing => ASYMMETRIC large-signal droop-vs-recovery that
//    the symmetric linear model cannot reproduce. NO dropout clamp; Vout~0.9V,
//    >=50mV headroom at all times.

//    Level shift ng -> ngn: NMOS source-follower mlsh (drain=vin gate=ng
//    source=ngn) loaded by a current source Ilsh so ngn = ng - Vgs(mlsh),
//    sized so the NMOS sink carries a small quiescent current at the OP.
//  Requires models nlv / plv at top level.
//  ============================================================
subckt ldo_classab (vin vout)
parameters vref=0.6 wp=200e-6 lp=0.3e-6 wn=30e-6 lnn=0.3e-6 wi=10e-6 li=0.5e-6 wm=10e-6 lm=0.5e-6 wt=20e-6 lt=0.5e-6 wb=20e-6 lb=0.5e-6 ib=10e-6 wls=10e-6 lls=0.5e-6 ils=200e-6 r1=500e3 r2=1e6 cout=2e-9 resr=15 cg=1e-12

//  --- push-pull output ---
//  PMOS source (sources current into vout); gate = OTA out ng
mp (vout ng vin vin) plv w=wp l=lp
//  NMOS sink  (sinks current from vout to gnd); gate = level-shifted ngn
mn (vout ngn 0 0) nlv w=wn l=lnn

//  --- level shift ng -> ngn (source follower + current-source load) ---
mlsh (vin ng ngn 0) nlv w=wls l=lls
Ilsh (ngn 0) isource dc=ils

//  --- 5T OTA (NMOS input pair, PMOS mirror load); neg fb: fb->diode, vref->out ---
m1 (n1 fb vtail 0) nlv w=wi l=li
m2 (ng vrefn vtail 0) nlv w=wi l=li
m3 (n1 n1 vin vin) plv w=wm l=lm
m4 (ng n1 vin vin) plv w=wm l=lm
mtail (vtail nb 0 0) nlv w=wt l=lt

//  tail current mirror bias
mb (nb nb 0 0) nlv w=wb l=lb
Ibias (vin nb) isource dc=ib

//  internal reference
Vrefs (vrefn 0) vsource dc=vref

//  feedback divider  Vout = vref*(r1+r2)/r2 = 0.6*1.5M/1M = 0.9 V
R1 (vout fb) resistor r=r1
R2 (fb 0) resistor r=r2

//  on-chip output cap + ESR
Cout (vout ncesr) capacitor c=cout
Resr (ncesr 0) resistor r=resr

//  gate-node cap (OTA-output pole)
Cgate (ng 0) capacitor c=cg
ends ldo_classab
