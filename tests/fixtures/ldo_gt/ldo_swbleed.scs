// ---------------------------------------------------------------------------
// GENERATED by tools/gt_convert.py from ngspice/ldo_swbleed.lib -- do not hand-edit.
// Synthetic ground-truth circuit; regenerate with `python tools/gt_convert.py`.
// ---------------------------------------------------------------------------
simulator lang=spectre
//  ============================================================
//  GT variant -- ldo_swbleed : LOAD-THRESHOLD MODE SWITCH (A3)
//    A current-threshold-activated shunt damper. The pass-device current
//    equals the external load current; a small sense-PMOS replica (msen,
//    Vgs-offset off the pass gate ng) reproduces a load-tracking current,
//    compared at a high-impedance node `sdet` against a fixed Iref
//    (current-comparator -> SHARP threshold near ~170uA). Past the threshold
//    the shunt damper NMOS `mbleed` (W~40u) turns ON and switches in a
//    series Cblk-Rbl-Lbl branch from vout to gnd. That branch resonates at
//    f0=1/(2*pi*sqrt(Lbl*Cblk))~150kHz -> a SECOND, distinct Zout RLC NOTCH
//    that exists ONLY at high load (250u), ABSENT at 20u/121u (the model's
//    Zout fitter would select a 2nd RLC branch ONLY at the 250u corner).
//    The DC-blocking cap Cblk makes the damper draw ZERO DC current, so Vout
//    regulation is strictly untouched (Vout ~0.9V all corners) and the
//    circuit is small-signal STABLE at every fixed OP (ring-decay<1). Linear
//    at each OP; only the *structure* jumps between the 121u and 250u OPs.
//  Requires models nlv / plv at top level.
//  ============================================================
subckt ldo_swbleed (vin vout)
parameters vref=0.6 wp=30e-6 lp=0.3e-6 wi=10e-6 li=0.5e-6 wm=10e-6 lm=0.5e-6 wt=20e-6 lt=0.5e-6 wb=20e-6 lb=0.5e-6 ib=10e-6 r1=500e3 r2=1e6 cout=1e-9 resr=0.5 cg=1e-12 wsen=4e-6 voff=0.18 wref=4e-6 lref=0.5e-6 rref=560e3 wbl=40e-6 lbl=0.3e-6 rbl=2 lbl_h=56e-6 cblk=20e-9

//  ---- pass device (PMOS): source=vin gate=ng drain=vout bulk=vin ----
mp (vout ng vin vin) plv w=wp l=lp

//  ---- 5T OTA (NMOS input pair, PMOS mirror load); neg fb ----
m1 (n1 fb vtail 0) nlv w=wi l=li
m2 (ng vrefn vtail 0) nlv w=wi l=li
m3 (n1 n1 vin vin) plv w=wm l=lm
m4 (ng n1 vin vin) plv w=wm l=lm
mtail (vtail nb 0 0) nlv w=wt l=lt
mb (nb nb 0 0) nlv w=wb l=lb
Ibias (vin nb) isource dc=ib
Vrefs (vrefn 0) vsource dc=vref

//  ---- feedback divider ----
R1 (vout fb) resistor r=r1
R2 (fb 0) resistor r=r2

//  ---- on-chip output cap + ESR ----
Cout (vout ncesr) capacitor c=cout
Resr (ncesr 0) resistor r=resr
Cgate (ng 0) capacitor c=cg

//  ---- LOAD-CURRENT SENSE w/ Vgs-OFFSET + CURRENT-COMPARATOR THRESHOLD ----
//    The pass-device source-gate voltage Vsg=vin-ng tracks the load current
//    monotonically (more load -> ng lower -> bigger |Vsg|). A replica sense
//    PMOS `msen` shares the gate `ng` but its SOURCE sits a fixed offset
//    `voff` below vin (rail `vsrc`), so its current Isen(ng) rises steeply
//    (sub-threshold exponential) with load.  Isen is compared, at the
//    high-impedance node `sdet`, against a fixed reference sink current
//    Iref (Rref-set, mirrored mrefd->mref). Below the cross-over load the
//    reference wins -> sdet pulled to gnd (mbleed OFF); above it the sense
//    current wins -> sdet swings up to vsrc (mbleed ON). Both ends are
//    current sources => HIGH GAIN at the cross-over => a SHARP load
//    threshold near ~170uA. All branches draw only ~1uA -> DC-negligible.
Voff (vin vsrc) vsource dc=voff
msen (sdet ng vsrc vsrc) plv w=wsen l=lp
//  reference current ~1uA (Rref from vin into a diode NMOS), mirrored to sink at sdet
Rref (vin nrefd) resistor r=rref
mrefd (nrefd nrefd 0 0) nlv w=wref l=lref
mref (sdet nrefd 0 0) nlv w=wref l=lref

//  ---- THRESHOLD-ACTIVATED SHUNT DAMPER from vout to gnd ----
//    gate driven by detector node sdet; mbleed sub-Vth (off) at low load,
//    conducts above threshold.  Series Cblk-Rbl-Lbl through mbleed: the
//    DC-blocking cap (cblk) makes the branch draw ZERO DC current (Vout
//    regulation strictly untouched), while its series R-L-C resonance with
//    nothing-but-itself presents a low-impedance NOTCH on vout at
//    f0=1/(2*pi*sqrt(lbl_h*cblk)) ~ 0.5MHz -- a SECOND, distinct Zout RLC
//    feature that appears ONLY when mbleed conducts (high load).  Below
//    threshold mbleed is open -> branch invisible (single resonance only).
Cblk (vout ncb) capacitor c=cblk
Rbl (ncb nrl) resistor r=rbl
Lbl (nrl nbl) inductor l=lbl_h
mbleed (nbl sdet 0 0) nlv w=wbl l=lbl
ends ldo_swbleed
