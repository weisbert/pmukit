// ---------------------------------------------------------------------------
// GENERATED by tools/gt_convert.py from ngspice/ldo_qbow.lib -- do not hand-edit.
// Synthetic ground-truth circuit; regenerate with `python tools/gt_convert.py`.
// ---------------------------------------------------------------------------
simulator lang=spectre
subckt ldo_qbow (vin vout)
parameters vref=0.6 wp=30e-6 lp=0.3e-6 wi=10e-6 li=0.5e-6 wm=10e-6 lm=0.5e-6 wt=20e-6 lt=0.5e-6 wb=20e-6 lb=0.5e-6 ib=10e-6 r1=500e3 r2=1e6 cout=1e-9 resr=0.5 cg=1e-12 cd=40e-9 rd=60 ld=0.5e-6 cp=16e-9 rld=50000
mp (vout ng vin vin) plv w=wp l=lp
m1 (n1 fb vtail 0) nlv w=wi l=li
m2 (ng vrefn vtail 0) nlv w=wi l=li
m3 (n1 n1 vin vin) plv w=wm l=lm
m4 (ng n1 vin vin) plv w=wm l=lm
mtail (vtail nb 0 0) nlv w=wt l=lt
mb (nb nb 0 0) nlv w=wb l=lb
Ibias (vin nb) isource dc=ib
Vrefs (vrefn 0) vsource dc=vref
R1 (vout fb) resistor r=r1
R2 (fb 0) resistor r=r2
Cout (vout ncesr) capacitor c=cout
Resr (ncesr 0) resistor r=resr
Cgate (ng 0) capacitor c=cg
//  ---------------------------------------------------------------- mid-bow on Zout
//  This LDO produces a NON-MONOTONIC Zout resonance vs load: Q = 1.5 / 16.5 / 11.1
//  at 20u / 121u / 250u -- a clear MID-peak (the base LDO is monotone-rising Q
//  4.5/16.6/18.7). The output LC resonance moves up with load (~0.94/1.78/2.1 MHz);
//  a band-stop (notch) damping snubber tuned to the 121u resonance bends the LIGHT
//  corner down so the mid corner stands out:
//   - DC-blocked by Csnub (no load-reg hit), Rd dissipates into a parallel L||C
//     tank whose Q/width is set by Rld. The tank is HIGH-Z only at its resonance
//     f0 = 1/(2pi sqrt(ld*cp)) ~ 1.78 MHz, so the branch is nearly OPEN (weak
//     damping) right at the 121u peak -- left SHARP -- but LOW-Z (strong broadband
//     damping) below it, crushing the light-load 20u resonance to ~Q1.5.
//   - ld SMALL / cp LARGE keeps the tank-L vs Cout parasitic resonance out of band.
//  Result: peak |Z| ~ 126 / 384 / 204 ohm -> Zpk(121)/Zpk(20) ~ 3.0 (sharp mid-bow
//  on the light side). See build notes for the 250u-side limit.
Csnub (vout nsnub) capacitor c=cd
Rsnub (nsnub ntank) resistor r=rd
Ltank (ntank 0) inductor l=ld
Cptank (ntank 0) capacitor c=cp
Rltank (ntank 0) resistor r=rld
ends ldo_qbow
