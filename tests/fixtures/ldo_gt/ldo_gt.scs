// ---------------------------------------------------------------------------
// GENERATED by tools/gt_convert.py from ngspice/ldo_gt.lib -- do not hand-edit.
// Synthetic ground-truth circuit; regenerate with `python tools/gt_convert.py`.
// ---------------------------------------------------------------------------
simulator lang=spectre
//  ============================================================
//  Ground-truth LDO subcircuit
//    ports: vin vout   (global 0 = gnd)
//    PMOS pass + 5T NMOS-input OTA + R divider + internal Vref
//    On-chip Cout (+ESR) is INSIDE the subckt = part of the LDO.
//    Any EXTERNAL decap belongs in the testbench (defect-6 boundary).
//  Requires models nlv / plv to be defined at top level.
//  ============================================================
subckt ldo_gt (vin vout)
parameters vref=0.6 wp=30e-6 lp=0.3e-6 wi=10e-6 li=0.5e-6 wm=10e-6 lm=0.5e-6 wt=20e-6 lt=0.5e-6 wb=20e-6 lb=0.5e-6 ib=10e-6 r1=500e3 r2=1e6 cout=1e-9 resr=0.5 cg=1e-12

//  pass device (PMOS): source=vin gate=ng drain=vout bulk=vin
mp (vout ng vin vin) plv w=wp l=lp

//  5T OTA (NMOS input pair, PMOS mirror load); neg fb: fb->diode side, vref->out
m1 (n1 fb vtail 0) nlv w=wi l=li
m2 (ng vrefn vtail 0) nlv w=wi l=li
m3 (n1 n1 vin vin) plv w=wm l=lm
m4 (ng n1 vin vin) plv w=wm l=lm
mtail (vtail nb 0 0) nlv w=wt l=lt

//  tail current mirror bias
mb (nb nb 0 0) nlv w=wb l=lb
Ibias (vin nb) isource dc=ib

//  internal reference
Vrefs (vrefn 0) vsource dc=vref

//  feedback divider
R1 (vout fb) resistor r=r1
R2 (fb 0) resistor r=r2

//  on-chip output cap + ESR
Cout (vout ncesr) capacitor c=cout
Resr (ncesr 0) resistor r=resr

//  gate-node cap: knob to place the OTA-output pole (loop Q / peaking)
Cgate (ng 0) capacitor c=cg
ends ldo_gt
