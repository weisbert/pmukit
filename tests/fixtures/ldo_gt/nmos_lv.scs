// ---------------------------------------------------------------------------
// GENERATED by tools/gt_convert.py from ngspice/nmos_lv.mod -- do not hand-edit.
// Synthetic ground-truth circuit; regenerate with `python tools/gt_convert.py`.
// ---------------------------------------------------------------------------
simulator lang=spectre
//  Low-voltage NMOS BSIM3v3.3.0 (Berkeley default params, Vth0/Tox tuned for ~1.05V operation)
simulator lang=spice
.model nlv nmos level=49 version=3.3 tnom=27.0 nch=2.498E+17
+ tox=3.5E-09 xj=1.00000E-07 lint=9.36e-8 wint=1.47e-7 vth0=0.30 k1=.756
+ k2=-3.83e-2 k3=-2.612 dvt0=2.812 dvt1=0.462 dvt2=-9.17e-2 nlx=3.52291E-08
+ w0=1.163e-6 k3b=2.233 vsat=86301.58 ua=6.47e-9 ub=4.23e-18 uc=-4.706281E-11
+ rdsw=650 u0=388.3203 wr=1 a0=.3496967 ags=.1 b0=0.546
+ b1=1 dwg=-6.0E-09 dwb=-3.56E-09 prwb=-.213 keta=-3.605872E-02 a1=2.778747E-02
+ a2=.9 voff=-6.735529E-02 nfactor=1.139926 cit=1.622527E-04 cdsc=-2.147181E-05 cdscb=0
+ dvt0w=0 dvt1w=0 dvt2w=0 cdscd=0 prwg=0 eta0=1.0281729E-02
+ etab=-5.042203E-03 dsub=.31871233 pclm=1.114846 pdiblc1=2.45357E-03 pdiblc2=6.406289E-03 drout=.31871233
+ pscbe1=5000000 pscbe2=5E-09 pdiblcb=-.234 pvag=0 delta=0.01 wl=0
+ ww=-1.420242E-09 wwl=0 wln=0 wwn=.2613948 ll=1.300902E-10 lw=0
+ lwl=0 lln=.316394 lwn=0 kt1=-.3 kt2=-.051 at=22400
+ ute=-1.48 ua1=3.31E-10 ub1=2.61E-19 uc1=-3.42e-10 kt1l=0 prt=764.3
+ cgso=1.5e-10 cgdo=1.5e-10 cj=1e-3 cjsw=1e-10 noimod=1 kf=4e-29
+ af=1 ef=1
simulator lang=spectre
