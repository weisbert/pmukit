// ---------------------------------------------------------------------------
// GENERATED by tools/gt_convert.py from ngspice/ldo_v2_capless.lib -- do not hand-edit.
// Synthetic ground-truth circuit; regenerate with `python tools/gt_convert.py`.
// ---------------------------------------------------------------------------
simulator lang=spectre
//  ============================================================
//  GT variant V2 -- CAP-LESS / small-Cout, high-UGB LDO
//    Stresses: the project's foundational "spur band is ABOVE UGB -> linear"
//              finding (here UGB is pushed up toward the 8 MHz spur band), and
//              whether the 2-branch RLC Zout still fits when the resonance moves up.
//    Same PMOS-pass / 5T-OTA core as base, but Cout is small (50 pF) and the gate
//    pole (cg) is the internal compensation knob. Tuned for a stable, high-f peak.
//  ============================================================
subckt ldo_v2_capless (vin vout)
parameters vref=0.6 wp=30e-6 lp=0.3e-6 wi=10e-6 li=0.5e-6 wm=10e-6 lm=0.5e-6 wt=20e-6 lt=0.5e-6 wb=20e-6 lb=0.5e-6 ib=40e-6 r1=500e3 r2=1e6 cout=100e-12 resr=120 cg=3e-12 cf=1e-12

mp (vout ng vin vin) plv w=wp l=lp

m1 (n1 fb vtail 0) nlv w=wi l=li
m2 (ng vrefn vtail 0) nlv w=wi l=li
m3 (n1 n1 vin vin) plv w=wm l=lm
m4 (ng n1 vin vin) plv w=wm l=lm
mtail (vtail nb 0 0) nlv w=wt l=lt
mb (nb nb 0 0) nlv w=wb l=lb
Ibias (vin nb) isource dc=ib
Vrefs (vrefn 0) vsource dc=vref

R1 (vout fb) resistor r=r1
R2 (fb 0) resistor r=r2
Cf (vout fb) capacitor c=cf
Cout (vout ncesr) capacitor c=cout
Resr (ncesr 0) resistor r=resr
Cgate (ng 0) capacitor c=cg
ends ldo_v2_capless
