// ---------------------------------------------------------------------------
// GENERATED by tools/gt_convert.py from ngspice/ldo_v10_3lc.lib -- do not hand-edit.
// Synthetic ground-truth circuit; regenerate with `python tools/gt_convert.py`.
// ---------------------------------------------------------------------------
simulator lang=spectre
//  ============================================================
//  GT variant V10 -- MULTI-STAGE PDN: >2 Zout resonances (order exceeded)
//    Stresses: the Zout fitter realizes at most TWO R||L||C branches (+ Cout/ESR),
//              so its driving-point impedance can show at most ~2 resonant features.
//              A real high-current rail has a MULTI-STAGE decoupling network: an on-die
//              cap, then package/trace inductance to a ceramic mid cap, then more
//              inductance to a bulk board cap. That cap-L-cap-L-cap ladder produces
//              MULTIPLE anti-resonances on top of the loop resonance -> THREE-plus
//              distinct Zout features. The 2-branch model can capture the two dominant
//              ones and must MISS the third = the Zout-ORDER generalization finding
//              (zband residual at the un-modeled resonance; a documented floor).
//    Distinct from v7_esl (a single inductive HF tail, no resonance structure) and
//    v8_dlc (a single anti-resonance NOTCH). Realistic for Target-B-class rails.
//    Same PMOS-pass / 5T-OTA core as base; the output network is a 3-cap PDN ladder.
//    ports: vin vout  (global 0 = gnd).  Vout ~ 0.9 V.
//  ============================================================
subckt ldo_v10_3lc (vin vout)
parameters vref=0.6 wp=30e-6 lp=0.3e-6 wi=10e-6 li=0.5e-6 wm=10e-6 lm=0.5e-6 wt=20e-6 lt=0.5e-6 wb=20e-6 lb=0.5e-6 ib=10e-6 r1=500e3 r2=1e6 cout=200e-12 resr=0.1 cg=1e-12 l1=3e-9 cmid=2e-9 esrm=0.15 l2=8e-9 cbulk=10e-9 esrb=0.1

//  pass device (PMOS): drives the on-die output node vout
mp (vout ng vin vin) plv w=wp l=lp

//  5T OTA (NMOS input pair, PMOS mirror load); neg fb: fb->diode side, vref->out
m1 (n1 fb vtail 0) nlv w=wi l=li
m2 (ng vrefn vtail 0) nlv w=wi l=li
m3 (n1 n1 vin vin) plv w=wm l=lm
m4 (ng n1 vin vin) plv w=wm l=lm
mtail (vtail nb 0 0) nlv w=wt l=lt

//  tail current mirror bias
mb (nb nb 0 0) nlv w=wb l=lb
Ibias (vin nb) isource dc=ib

//  internal reference
Vrefs (vrefn 0) vsource dc=vref

//  feedback divider (senses the on-die output node)
R1 (vout fb) resistor r=r1
R2 (fb 0) resistor r=r2

//  --- on-die cap (small, low ESR) ---
Cout (vout ncesr) capacitor c=cout
Resr (ncesr 0) resistor r=resr

//  --- decoupling ladder hanging off vout: L1 -> ceramic mid cap -> L2 -> bulk cap ---
L1 (vout nm1) inductor l=l1
Cmid (nm1 ncm) capacitor c=cmid
Resrm (ncm 0) resistor r=esrm
L2 (nm1 nm2) inductor l=l2
Cbulk (nm2 ncb) capacitor c=cbulk
Resrb (ncb 0) resistor r=esrb

//  gate-node cap
Cgate (ng 0) capacitor c=cg
ends ldo_v10_3lc
