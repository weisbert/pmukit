// ---------------------------------------------------------------------------
// GENERATED by tools/gt_convert.py from ngspice/ldo_v1_nmos.lib -- do not hand-edit.
// Synthetic ground-truth circuit; regenerate with `python tools/gt_convert.py`.
// ---------------------------------------------------------------------------
simulator lang=spectre
//  ============================================================
//  GT variant V1 -- NMOS-pass / SOURCE-FOLLOWER LDO
//    Stresses the "there is always a resonance" assumption.  Source-follower pass
//    => intrinsic Zout ~ 1/gm.  A WIDE pass (high gm) makes 1/gm small, and a LOW
//    DC loop gain (Rota lowered by Rload on the OTA output) keeps Zpk/Zlf (the loop
//    gain) small => LOW and ~FLAT Zout with little peaking (low Q).  High PSRR.
//    ports: vin vout  (global 0 = gnd).  Vout ~ 0.55 V.
//    Device geometries are literals (BSIM op for this SF loop does not converge with
//    W/L as {param} expressions; cout/resr/cg stay params).
//  ============================================================
subckt ldo_v1_nmos (vin vout)
parameters cout=1e-9 resr=30 cg=2e-12

//  --- NMOS source-follower pass: very wide => high gm => low 1/gm (low flat Zout) ---
mpass (vin ng vout vout) nlv w=1000e-6 l=0.5e-6

//  --- NMOS-input 5T OTA, PMOS mirror load, output ng ; m2 gate=fb (neg fb) ---
m1 (n1 vrefn vtail 0) nlv w=20e-6 l=0.5e-6
m2 (ng fb vtail 0) nlv w=20e-6 l=0.5e-6
m3 (n1 n1 vin vin) plv w=20e-6 l=0.5e-6
m4 (ng n1 vin vin) plv w=20e-6 l=0.5e-6
mtail (vtail nb 0 0) nlv w=40e-6 l=0.5e-6
mb (nb nb 0 0) nlv w=20e-6 l=0.5e-6
Ibias (vin nb) isource dc=10e-6

//  internal reference
Vrefs (vrefn 0) vsource dc=0.50

//  OTA-output load resistor: lowers Rota => lowers DC loop gain => lowers Q
Rng (ng vout) resistor r=50e3

//  feedback divider (resistive DC path -> robust op convergence)
R1 (vout fb) resistor r=200e3
R2 (fb 0) resistor r=2e6

//  on-chip output cap + ESR ; gate-node cap
Cout (vout ncesr) capacitor c=cout
Resr (ncesr 0) resistor r=resr
Cgate (ng 0) capacitor c=cg
ends ldo_v1_nmos
