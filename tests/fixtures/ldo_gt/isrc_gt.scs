// ---------------------------------------------------------------------------
// GENERATED by tools/gt_convert.py from ngspice/isrc_gt.lib -- do not hand-edit.
// Synthetic ground-truth circuit; regenerate with `python tools/gt_convert.py`.
// ---------------------------------------------------------------------------
simulator lang=spectre
//  ============================================================
//  MOS current-source GROUND-TRUTH library  (transistor-level)

//  NOTE: two header comments that named real customer cells were replaced with
//        generic descriptions before this file entered the public repo.

//  The OBJECT we model is MOS-transistor-level (real current mirrors, run in
//  SPICE); the DELIVERABLE model is behavioral -- exactly the LDO pattern
//  (ground_truth/ldo_gt.cir is device-level, the fitted model is behavioral).

//  Each subckt:  ports (vdd out), global 0 = gnd.
//    SINK   : NMOS output pulls current FROM `out` to gnd  (+I into the pin).
//    SOURCE : PMOS output pushes current FROM vdd into `out`.
//  The testbench forces `out` to a compliance voltage and reads the delivered
//  current -> Idc / I-V knee / Y(s) / dIout/dVdd (PSRR) / current-noise / Idc(T).
//  Requires models nlv / plv at top level.  Device geometries are LITERALS
//  (BSIM3 op convergence; cf. the ldo_v1 note); only bias knobs are {params}.

//  >= 8 DELIBERATELY DIVERSE archetypes so a behavioral fit cannot overfit a
//  single topology/operating point -- they span polarity, output impedance,
//  compliance knee, current-noise, temperature law (PTAT vs CTAT), and PSRR
//  sign.  This mirrors the LDO variants[] generalization set.
//  ============================================================

//  ---- V1: simple NMOS mirror SINK, ideal Iref, ~1.8uA -----------------------
//    low-ish rout (single ro), early knee, near-IDEAL PSRR (Iref supply-indep).
//    archetype for a poly-resistor-biased ~1.8 uA sink.
subckt isrc_v1_nmos_simple (vdd out)
parameters iref=1.8e-6
Iref (vdd nd) isource dc=iref
m1 (nd nd 0 0) nlv w=2e-6 l=1e-6
mout (out nd 0 0) nlv w=2e-6 l=1e-6
ends isrc_v1_nmos_simple

//  ---- V2: cascode NMOS SINK, ideal Iref, ~1.0uA -----------------------------
//    very high rout (gm*ro*ro), HIGHER compliance (~2*Vov), near-ideal PSRR.
subckt isrc_v2_nmos_cascode (vdd out)
parameters iref=1.0e-6
Iref (vdd nc) isource dc=iref
mcd (nc nc nd 0) nlv w=2e-6 l=1e-6 // top diode  -> vcas=nc (~2Vgs)
m1 (nd nd 0 0) nlv w=2e-6 l=1e-6 // bottom diode -> vbias=nd
mout (od nd 0 0) nlv w=2e-6 l=1e-6 // output bottom device
mcas (out nc od 0) nlv w=2e-6 l=1e-6 // cascode device (gate=nc)
ends isrc_v2_nmos_cascode

//  ---- V3: long-channel simple NMOS SINK, ideal Iref, ~0.8uA -----------------
//    L=4u -> high rout AND low compliance, LOW current-noise (big gate area).
//    distinct (rout, knee, noise) point from V1 at the same simple topology.
subckt isrc_v3_nmos_long (vdd out)
parameters iref=0.8e-6
Iref (vdd nd) isource dc=iref
m1 (nd nd 0 0) nlv w=8e-6 l=4e-6
mout (out nd 0 0) nlv w=8e-6 l=4e-6
ends isrc_v3_nmos_long

//  ---- V4: simple PMOS mirror SOURCE, ideal Iref, ~1.0uA ---------------------
//    OPPOSITE polarity (sources into `out` from vdd); knee at HIGH out (out->vdd);
//    PMOS device -> different noise/temp; PSRR set by output ro to vdd.
subckt isrc_v4_pmos_simple (vdd out)
parameters iref=1.0e-6
Iref (np 0) isource dc=iref
mp1 (np np vdd vdd) plv w=4e-6 l=1e-6
mout (out np vdd vdd) plv w=4e-6 l=1e-6
ends isrc_v4_pmos_simple

//  ---- V5: cascode PMOS SOURCE, ideal Iref, ~2.0uA ---------------------------
//    high-rout source; knee near out->vdd-2*Vov; PMOS cascode.
subckt isrc_v5_pmos_cascode (vdd out)
parameters iref=2.0e-6
Iref (npc 0) isource dc=iref
mpb (npb npb vdd vdd) plv w=4e-6 l=1e-6 // bottom diode -> vbias=npb=vdd-Vgs
mpc (npc npc npb vdd) plv w=4e-6 l=1e-6 // stacked diode -> vcas=npc=vdd-2Vgs
mout (oc npb vdd vdd) plv w=4e-6 l=1e-6 // output top device (mirror of mpb)
mcas (out npc oc vdd) plv w=4e-6 l=1e-6 // cascode device (gate=npc)
ends isrc_v5_pmos_cascode

//  ---- V6: PTAT constant-gm (beta-multiplier) reference, NMOS SINK, ~1.5uA ----
//    self-biased; sized toward weak inversion so dVgs ~ n*kT/q*ln(K) -> I ~ PTAT.
//    archetype for a trimmable PTAT ~1.5 uA sink (linear-in-absolute-T).
subckt isrc_v6_ptat (vdd out)
parameters rs=600e3 wout=150e-6
//  self-biased constant-gm core: PMOS mirror (gates=n2) forces I(n1)=I(n2);
//  NMOS gates common=n1; M2 is K=8x wide with SOURCE-degeneration Rs ->
//    I*Rs = Vgs(M1)-Vgs(M2) = dVgs ~ n*(kT/q)*ln(K)  => I ~ PTAT.
mp1 (n1 n2 vdd vdd) plv w=8e-6 l=2e-6
mp2 (n2 n2 vdd vdd) plv w=8e-6 l=2e-6
mn1 (n1 n1 0 0) nlv w=10e-6 l=2e-6
mn2 (n2 n1 ns 0) nlv w=80e-6 l=2e-6
Rs (ns 0) resistor r=rs
//  startup: weak leak so the all-off (I=0) state is not the solver's solution
Rstart (vdd n1) resistor r=500e6
//  output mirror off the NMOS gate node n1
mout (out n1 0 0) nlv w=wout l=2e-6
ends isrc_v6_ptat

//  ---- V7: resistor-biased NMOS SINK (no ideal Iref), ~1.2uA -----------------
//    Iref=(vdd-Vgs)/Rref -> STRONG dIout/dVdd (POOR, positive-sign PSRR);
//    CTAT-leaning tempco.  The PSRR-sign / supply-pushing outlier (G4/G8).
subckt isrc_v7_nmos_rbias (vdd out)
parameters rref=520e3
Rref (vdd nd) resistor r=rref
m1 (nd nd 0 0) nlv w=3e-6 l=1e-6
mout (out nd 0 0) nlv w=3e-6 l=1e-6
ends isrc_v7_nmos_rbias

//  ---- V8: Wilson NMOS SINK, ideal Iref, ~0.6uA ------------------------------
//    feedback-boosted rout (3-transistor Wilson); distinct PSRR/noise signature.
subckt isrc_v8_wilson (vdd out)
parameters iref=0.6e-6
Iref (vdd nin) isource dc=iref
mw1 (nin nd 0 0) nlv w=2e-6 l=1e-6 // input device, drain=nin
mw2 (nd nd 0 0) nlv w=2e-6 l=1e-6 // diode reference, sets nd
mw3 (out nin nd 0) nlv w=2e-6 l=1e-6 // output device (Wilson cascode)
ends isrc_v8_wilson

//  ============================================================
//  ADVERSARIAL OVERFIT-PROBE current-source DUTs (round 3)
//    B1 inflect_ctat_ptat   : U/inflected Idc(T) -> 3-temp line misses interior (HELDOUT_IDC_TEMPS)
//    B2 double_cascode_2zero: TWO separated output-admittance zeros (single zero-pole can't hold)
//    B3 bias_dependent_psrr_flip: dIout/dVdd SIGN flips across compliance (single-vc gdd blind)
//    B4 tempload_xterm      : compliance KNEE moves with T while Idc@vc flat (broken separability)
//  See HANDOFF_ADVERSARIAL_OVERFIT_PROBE.md / isrc_variants.py. Built+vetted 2026-06-25.
//  ============================================================

//  adversarial overfit probe DUT B1: U-shaped / inflected Idc(T)
//  PTAT beta-mult branch (rises ~linearly with T) summed with a FIXED-Vgs
//  weak-inversion NMOS (Isub ~ Vt^2 * exp((Vgs-Vth)/nVt), strongly CONVEX/
//  super-linear in T) so the SUM bends -> 3-pt line misses 25C/85C by >5%.
subckt isrc_inflect_ctat_ptat (vdd out)
//  ---- PTAT beta-multiplier core (I*Rs = dVgs, PTAT) ----
mp1 (n1 n2 vdd vdd) plv w=8e-6 l=2e-6
mp2 (n2 n2 vdd vdd) plv w=8e-6 l=2e-6
mn1 (n1 n1 0 0) nlv w=10e-6 l=2e-6
mn2 (n2 n1 ns 0) nlv w=80e-6 l=2e-6
Rs (ns 0) resistor r=600e3
Rstart (vdd n1) resistor r=500e6
//  PTAT output mirror -> sinks out (RISES ~linearly with T)
mout_ptat (out n1 0 0) nlv w=80e-6 l=2e-6
//  ---- weak-inversion fixed-Vgs branch (strongly convex in T) ----
//  hold the gate at a fixed sub-Vth voltage via a resistor divider off vdd
Rg1 (vdd ng) resistor r=40e6
Rg2 (ng 0) resistor r=11e6
mout_sub (out ng 0 0) nlv w=12e-6 l=2e-6
ends isrc_inflect_ctat_ptat

//  ---- B2: DOUBLE-CASCODE (triple-stacked) NMOS SINK, two output-admittance zeros
//    A 3-high output stack mout/mcas1/mcas2 gives gm*ro^3 (very high rout). The two
//    internal high-Z cascode source nodes (n_a lower, n_b upper) each contribute a
//    zero in Y(s)=i(out)/v(out). Small node caps Cm (lower) / Co (upper) place the
//    two zeros ~1.5 decades apart. Gate rails from a 3-diode bias stack off Iref.
//    Idc ~0.8-1uA sink, very high rout. Adversarial: g0*(1+s/wz)/(1+s/wp)+sCp
//    (single zero) cannot fit TWO separated zero corners.
subckt isrc_double_cascode_2zero (vdd out)
parameters iref=1.0e-6 cm=8e-12 co=300e-15
//  --- 3-diode bias stack: three gate rails vb1<vb2<vb3 ---
Iref (vdd vb3) isource dc=iref
md3 (vb3 vb3 vb2 0) nlv w=2e-6 l=1e-6 // top diode    -> vb3 (gate of mcas2)
md2 (vb2 vb2 vb1 0) nlv w=2e-6 l=1e-6 // mid diode    -> vb2 (gate of mcas1)
md1 (vb1 vb1 0 0) nlv w=2e-6 l=1e-6 // bottom diode -> vb1 (gate of mout)
//  --- triple-stacked output sink: out -> n_b -> n_a -> gnd ---
mout (n_a vb1 0 0) nlv w=2e-6 l=1e-6 // bottom device, gate=vb1
mcas1 (n_b vb2 n_a 0) nlv w=2e-6 l=1e-6 // first cascode, gate=vb2, source n_a
mcas2 (out vb3 n_b 0) nlv w=2e-6 l=1e-6 // second cascode, gate=vb3, source n_b
//  --- small node caps set the two zero corners ~1.5 decades apart ---
Cm (n_a 0) capacitor c=cm // lower internal node -> lower zero
Co (n_b 0) capacitor c=co // upper internal node -> upper zero
ends isrc_double_cascode_2zero

//  ============================================================
//  ADVERSARIAL probe DUT: isrc_bias_dependent_psrr_flip  (B3 target)

//  LF dIout/dVdd (supply coupling) FLIPS SIGN across compliance:
//  one sign at Vo=0.3, ~0 near Vo=0.5, opposite sign at Vo=0.7.

//  MECHANISM = two competing supply-coupling paths:
//    PATH A (resistor-to-vdd NMOS mirror): Rref from vdd sets the gate of the
//      NMOS sink. Vdd up -> gate up -> mout pulls MORE from out -> one sign of
//      dIout/dVdd. Vo-INDEPENDENT coupling (dominant at LOW Vo).
//    PATH B (PMOS aux sourcing INTO out, gate from an out-divider): a PMOS pushes
//      current FROM vdd INTO out -> REDUCES the net sunk current -> OPPOSITE sign.
//      Its gate is set by a divider from `out`, so as Vo rises the PMOS Vsg/headroom
//      grows and its supply coupling OVERTAKES path A, inverting the net sign.
//  Both devices stay in saturation across Vo=0.3..0.7 -> a real competing-path
//  flip, not a knee artifact.  Sink, Idc ~1-1.5uA.
//  ============================================================
subckt isrc_bias_dependent_psrr_flip (vdd out)
parameters rref=520e3 rtop=2.3e6 rbot=3e6
//  --- PATH A: resistor-to-vdd biased NMOS sink (Vo-independent supply coupling) ---
Rref (vdd nd) resistor r=rref
m1 (nd nd 0 0) nlv w=3e-6 l=1e-6
mout (out nd 0 0) nlv w=3e-6 l=1e-6
//  --- PATH B: PMOS aux sources INTO out; gate from out-divider (grows with Vo) ---
Rtop (vdd ng) resistor r=rtop
Rbot (ng out) resistor r=rbot
maux (out ng vdd vdd) plv w=6e-6 l=1e-6
ends isrc_bias_dependent_psrr_flip

//  adversarial overfit probe DUT B4: temperature x compliance CROSS-TERM
//  (broken separability of Idc(T,Vo)).

//  TARGET (crossval_isrc.gate_iv_temps): the GT compliance KNEE (0.5*plateau Vo
//  crossing) MOVES with temperature > 40 mV across the fit temps WHILE a separable
//  model [tempco(T)@vc x nominal IV-shape(Vo)] mis-predicts the near-knee window by
//  > 5%.  A temp-independent Vknee/g0 behavioral model cannot bend -> B4 exposed.
//  The headline ptat_err@vc stays clean (the model fits Idc(T)@vc), so the scalar
//  PASS gate is fooled while I(Vo,T) is wrong on the load line.

//  MECHANISM (two parallel NMOS sinks summed at `out`):
//   (B) PTAT-biased output device with HEAVY PTAT SOURCE DEGENERATION (Rsout carries
//       the device's PTAT current).  Its Vds,sat = Vov + I_ptat(T)*Rsout, so its
//       compliance knee CLIMBS strongly with T (cold saturates at low Vo -> wide
//       compliance; hot the knee climbs -> compliance narrows).  This branch sets the
//       lower half of the IV, so the composite 0.5*plateau knee tracks its T-climb.
//   (A) HIGH-rout ideal-Iref CASCODE sink fills the plateau with a milder tempco,
//       diluting the bare-PTAT mid-range ratio (~1.6) down to a more benign ~1.3 at
//       vc=0.5 without filling the low-Vo knee region (so the moving knee survives).

//  Net (vc=0.5): Idc ~ 1.4/1.7/1.9 uA (-40/55/125C), ratio ~1.32; the compliance
//  knee moves ~0.056 -> 0.106 V (dVk ~ 47 mV > 40); near-knee separable-model error
//  ~19% (>> 5).  Idc target ~1.5-1.8 uA, sink.

//  All device geometries are LITERALS (BSIM3 OP convergence); requires nlv/plv.
subckt isrc_tempload_xterm (vdd out)
parameters rsout=320e3 iref=0.7e-6
//  ---- PTAT beta-multiplier core (I*Rs = dVgs ~ PTAT) ----
mp1 (n1 n2 vdd vdd) plv w=8e-6 l=2e-6
mp2 (n2 n2 vdd vdd) plv w=8e-6 l=2e-6
mn1 (n1 n1 0 0) nlv w=10e-6 l=2e-6
mn2 (n2 n1 ns 0) nlv w=80e-6 l=2e-6
Rs (ns 0) resistor r=600e3
Rstart (vdd n1) resistor r=500e6
//  ---- (B) PTAT sink with heavy PTAT source degeneration -> climbing 0.5-plateau knee
mpm (ndp n2 vdd vdd) plv w=1700e-6 l=2e-6 // multiply core current -> PTAT diode bias ndp
m1p (ndp ndp 0 0) nlv w=4e-6 l=1e-6
mout (out ndp nsrc 0) nlv w=400e-6 l=1e-6 // degenerated output device
Rsout (nsrc 0) resistor r=rsout // PTAT current * Rsout -> Vds,sat (knee) climbs w/ T
//  ---- (A) ideal-Iref cascode sink fills the plateau, milder tempco (dilutes the ratio)
Iref (vdd nc) isource dc=iref
mcd (nc nc nd2 0) nlv w=2e-6 l=1e-6
mb (nd2 nd2 0 0) nlv w=2e-6 l=1e-6
mob (od nd2 0 0) nlv w=2e-6 l=1e-6
mca (out nc od 0) nlv w=2e-6 l=1e-6
ends isrc_tempload_xterm
