// ---------------------------------------------------------------------------
// GENERATED by tools/gt_convert.py from ngspice/ldo_v4_ffpsrr.lib -- do not hand-edit.
// Synthetic ground-truth circuit; regenerate with `python tools/gt_convert.py`.
// ---------------------------------------------------------------------------
simulator lang=spectre
//  ============================================================
//  GT variant V4 -- FEEDFORWARD / NON-MINIMUM-PHASE PSRR LDO
//    Stresses: the PSRR = shelf x Zout assumption (shared poles, minimum-phase).
//              A supply feedforward injects a SECOND vin->vout path that partially
//              CANCELS the pass-device path, creating a PSRR notch + an RHP-zero ->
//              strongly non-minimum-phase PSRR (phase races ~390deg, NMPdeg ~55-72).
//    Mechanism: Cffb+Rffb couple vin ripple onto the feedback node 'fb'. The loop
//              then drives vout to partially track vin; this loop-borne supply path
//              competes with the direct pass-device supply path. Near ~1 MHz the two
//              paths reinforce (deep dip, |vout/vin|>1); above it they cancel and
//              rejection recovers steeply (the notch / RHP zero). The feedforward is
//              on the LOW-impedance fb node, NOT the high-Z gate, so it does not add
//              to the OTA-output pole -> the loop stays well damped. resr provides the
//              Cout-resonance damping zero that keeps Q in check.
//    Same PMOS-pass / 5T-OTA core as base + the supply feedforward network.
//  ============================================================
subckt ldo_v4_ffpsrr (vin vout)
parameters vref=0.6 wp=30e-6 lp=0.3e-6 wi=10e-6 li=0.5e-6 wm=10e-6 lm=0.5e-6 wt=20e-6 lt=0.5e-6 wb=20e-6 lb=0.5e-6 ib=10e-6 r1=500e3 r2=1e6 cout=1e-9 resr=5 cg=1e-12 cff=0e-12 cffb=3e-12 rffb=200e3

mp (vout ng vin vin) plv w=wp l=lp

m1 (n1 fb vtail 0) nlv w=wi l=li
m2 (ng vrefn vtail 0) nlv w=wi l=li
m3 (n1 n1 vin vin) plv w=wm l=lm
m4 (ng n1 vin vin) plv w=wm l=lm
mtail (vtail nb 0 0) nlv w=wt l=lt
mb (nb nb 0 0) nlv w=wb l=lb
Ibias (vin nb) isource dc=ib
Vrefs (vrefn 0) vsource dc=vref

R1 (vout fb) resistor r=r1
R2 (fb 0) resistor r=r2
Cout (vout ncesr) capacitor c=cout
Resr (ncesr 0) resistor r=resr
Cgate (ng 0) capacitor c=cg

//  optional residual gate feedforward (default off -- fb feedforward carries the notch)
Cff (vin ng) capacitor c=cff

//  supply feedforward onto the feedback node: a second vin->vout path (via the loop)
//  that partially cancels the pass-device path -> PSRR notch + RHP zero (non-min-phase)
Cffb (vin nffb) capacitor c=cffb
Rffb (nffb fb) resistor r=rffb
ends ldo_v4_ffpsrr
