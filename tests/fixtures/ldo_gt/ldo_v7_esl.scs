// ---------------------------------------------------------------------------
// GENERATED by tools/gt_convert.py from ngspice/ldo_v7_esl.lib -- do not hand-edit.
// Synthetic ground-truth circuit; regenerate with `python tools/gt_convert.py`.
// ---------------------------------------------------------------------------
simulator lang=spectre
//  ============================================================
//  GT variant V7 -- OUTPUT-CAP SERIES ESL (inductive HF Zout tail)
//    Stresses: the Zout model has NO series-output-inductance term -- it is
//              (R_a+sL_a) || (R_pl) || (ESR + 1/sC), so above the cap corner it
//              rolls off to the ESR floor and stays FLAT. A real output cap has a
//              series ESL: Cout - Resr - Lesl. That branch self-resonates at the
//              cap SRF (Zbranch minimum = Resr) and then RISES inductively (ωLesl)
//              above it. So the measured Zout(vout) dips to ~Resr at the SRF and
//              then climbs at HF -- the inductive tail the lumped model cannot fit.
//    This is exactly the package/board physics a real GHz part shows; it ties the
//    modeling-bandwidth ESL note and Target-B (characterize to 2 GHz via hf_stop).
//    Same PMOS-pass / 5T-OTA core as base; only the output-cap branch changes.
//    ports: vin vout  (global 0 = gnd).  Vout ~ 0.9 V.
//  ============================================================
subckt ldo_v7_esl (vin vout)
parameters vref=0.6 wp=30e-6 lp=0.3e-6 wi=10e-6 li=0.5e-6 wm=10e-6 lm=0.5e-6 wt=20e-6 lt=0.5e-6 wb=20e-6 lb=0.5e-6 ib=10e-6 r1=500e3 r2=1e6 cout=1e-9 resr=0.5 cg=1e-12 lesl=0.6e-9

//  pass device (PMOS): source=vin gate=ng drain=vout bulk=vin
mp (vout ng vin vin) plv w=wp l=lp

//  5T OTA (NMOS input pair, PMOS mirror load); neg fb: fb->diode side, vref->out
m1 (n1 fb vtail 0) nlv w=wi l=li
m2 (ng vrefn vtail 0) nlv w=wi l=li
m3 (n1 n1 vin vin) plv w=wm l=lm
m4 (ng n1 vin vin) plv w=wm l=lm
mtail (vtail nb 0 0) nlv w=wt l=lt

//  tail current mirror bias
mb (nb nb 0 0) nlv w=wb l=lb
Ibias (vin nb) isource dc=ib

//  internal reference
Vrefs (vrefn 0) vsource dc=vref

//  feedback divider
R1 (vout fb) resistor r=r1
R2 (fb 0) resistor r=r2

//  on-chip output cap WITH series ESL: Cout - Resr - Lesl to gnd
//  (SRF ~ 1/(2*pi*sqrt(Lesl*Cout)); for 0.6nH*1nF ~ 205 MHz, inductive above it)
Cout (vout ncesr) capacitor c=cout
Resr (ncesr ncl) resistor r=resr
Lesl (ncl 0) inductor l=lesl

//  gate-node cap: knob to place the OTA-output pole (loop Q / peaking)
Cgate (ng 0) capacitor c=cg
ends ldo_v7_esl
