// ---------------------------------------------------------------------------
// GENERATED by tools/gt_convert.py from ngspice/ldo_v8_dlc.lib -- do not hand-edit.
// Synthetic ground-truth circuit; regenerate with `python tools/gt_convert.py`.
// ---------------------------------------------------------------------------
simulator lang=spectre
//  ============================================================
//  GT variant V8 -- DOUBLE-LC / PI OUTPUT NETWORK (2 resonances + a NOTCH)
//    Stresses: the single-resonance / parallel-RLC Zout assumption. The output is
//              a PI network: an ON-DIE cap (Cd) at the regulated node vreg, a series
//              package/interconnect inductance Lint, and a BOARD cap (Cb=Cout) at the
//              external pin vout. The loop SENSES vreg (on-die), but the load and the
//              Zout/PSRR measurement are at the vout PIN -- so the pin sees a passive
//              two-cap-with-interconnect-L network on top of the regulated node.
//    Zout(vout) then shows:
//      - the loop resonance at LF (as usual),
//      - a SERIES-resonance NOTCH where Lint resonates with the near cap Cd
//        (Zbranch -> ~esrd, a deep dip), and
//      - an ANTI-resonance PEAK where Lint resonates with the board cap Cb.
//    A NOTCH (a deep magnitude dip) is something the model's parallel R||L||C-branch
//    topology CANNOT produce -> the generalization finding. The auto-extracted Cout
//    will also disagree with the true board cap (two caps + L) -- part of the finding.
//    Same PMOS-pass / 5T-OTA core as base; only the output network + sense node change.
//    ports: vin vout  (global 0 = gnd).  Vout ~ 0.9 V.
//  ============================================================
subckt ldo_v8_dlc (vin vout)
parameters vref=0.6 wp=30e-6 lp=0.3e-6 wi=10e-6 li=0.5e-6 wm=10e-6 lm=0.5e-6 wt=20e-6 lt=0.5e-6 wb=20e-6 lb=0.5e-6 ib=10e-6 r1=500e3 r2=1e6 cout=4.7e-9 resr=0.5 cg=1e-12 cd=1e-9 esrd=0.05 lint=2e-9

//  pass device (PMOS) drives the ON-DIE regulated node vreg
mp (vreg ng vin vin) plv w=wp l=lp

//  5T OTA (NMOS input pair, PMOS mirror load)
m1 (n1 fb vtail 0) nlv w=wi l=li
m2 (ng vrefn vtail 0) nlv w=wi l=li
m3 (n1 n1 vin vin) plv w=wm l=lm
m4 (ng n1 vin vin) plv w=wm l=lm
mtail (vtail nb 0 0) nlv w=wt l=lt

//  tail current mirror bias
mb (nb nb 0 0) nlv w=wb l=lb
Ibias (vin nb) isource dc=ib

//  internal reference
Vrefs (vrefn 0) vsource dc=vref

//  feedback divider SENSES the on-die node vreg
R1 (vreg fb) resistor r=r1
R2 (fb 0) resistor r=r2

//  on-die cap at vreg (near cap; low ESR -> deep notch)
Cd (vreg ncd) capacitor c=cd
Resrd (ncd 0) resistor r=esrd

//  package / interconnect inductance from the on-die node to the output pin
Lint (vreg vout) inductor l=lint

//  board cap at the output PIN (the bulk decap)
Cout (vout ncesr) capacitor c=cout
Resr (ncesr 0) resistor r=resr

//  gate-node cap
Cgate (ng 0) capacitor c=cg
ends ldo_v8_dlc
