// ---------------------------------------------------------------------------
// GENERATED by tools/gt_convert.py from ngspice/ldo_v9_vldo.lib -- do not hand-edit.
// Synthetic ground-truth circuit; regenerate with `python tools/gt_convert.py`.
// ---------------------------------------------------------------------------
simulator lang=spectre
//  ============================================================
//  GT variant V9 -- VERY-LOW-DROPOUT, large pass device (large-signal axis)
//    Stresses: the LTI / small-signal-validity assumption. The divider sets
//              Vout ~ 1.00 V from Vin = 1.05 V => only ~50 mV of dropout headroom.
//              The PMOS pass therefore sits in deep triode at the operating point.
//              Small-signal Zout/PSRR/noise are still well-behaved (the model should
//              FIT them), but the large load steps (trans_big 1mA, trans_slew 5mA)
//              demand a current swing the device cannot deliver at 50 mV headroom ->
//              it falls into DROPOUT (the gate rails), producing a large, strongly
//              NON-LINEAR droop. The DC dropout sweep also rolls off early.
//    So the finding is NOT a fit miss -- it is that the LTI model's VALIDITY ENVELOPE
//    must correctly NARROW here (the linearity-floor detection / systest large-signal
//    gate must fire). This is the amplitude axis, orthogonal to the freq-domain parts.
//    IDENTICAL device + core as base (wp=30u); the ONLY change is the divider, which
//    pushes Vout to ~1.00 V so only ~50 mV of headroom remains -> the dropout knee
//    falls to ~1 mA, so the standard trans_big (1mA) step now hits dropout (vs base,
//    where 1mA is recoverable). This isolates the low-dropout variable from sizing.
//    ports: vin vout  (global 0 = gnd).  Vout ~ 1.00 V (dropout ~50 mV).
//  ============================================================
subckt ldo_v9_vldo (vin vout)
parameters vref=0.6 wp=30e-6 lp=0.3e-6 wi=10e-6 li=0.5e-6 wm=10e-6 lm=0.5e-6 wt=20e-6 lt=0.5e-6 wb=20e-6 lb=0.5e-6 ib=10e-6 r1=400e3 r2=600e3 cout=1e-9 resr=0.5 cg=1e-12

//  pass device (PMOS): same width as base, but only ~50 mV of headroom -> deep triode
mp (vout ng vin vin) plv w=wp l=lp

//  5T OTA (NMOS input pair, PMOS mirror load); neg fb: fb->diode side, vref->out
m1 (n1 fb vtail 0) nlv w=wi l=li
m2 (ng vrefn vtail 0) nlv w=wi l=li
m3 (n1 n1 vin vin) plv w=wm l=lm
m4 (ng n1 vin vin) plv w=wm l=lm
mtail (vtail nb 0 0) nlv w=wt l=lt

//  tail current mirror bias
mb (nb nb 0 0) nlv w=wb l=lb
Ibias (vin nb) isource dc=ib

//  internal reference
Vrefs (vrefn 0) vsource dc=vref

//  feedback divider: Vout = vref*(R1+R2)/R2 = 0.6*1000k/600k = 1.00 V
R1 (vout fb) resistor r=r1
R2 (fb 0) resistor r=r2

//  on-chip output cap + ESR
Cout (vout ncesr) capacitor c=cout
Resr (ncesr 0) resistor r=resr

//  gate-node cap
Cgate (ng 0) capacitor c=cg
ends ldo_v9_vldo
