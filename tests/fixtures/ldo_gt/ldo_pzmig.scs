// ---------------------------------------------------------------------------
// GENERATED by tools/gt_convert.py from ngspice/ldo_pzmig.lib -- do not hand-edit.
// Synthetic ground-truth circuit; regenerate with `python tools/gt_convert.py`.
// ---------------------------------------------------------------------------
simulator lang=spectre
subckt ldo_pzmig (vin vout)
parameters vref=0.6 wp=30e-6 lp=0.3e-6 wi=10e-6 li=0.5e-6 wm=10e-6 lm=0.5e-6 wt=20e-6 lt=0.5e-6 wb=20e-6 lb=0.5e-6 ib=10e-6 r1=500e3 r2=1e6 cout=12e-9 resr=0.01 cg=6e-12 rg=80e3 cg2=1e-12
mp (vout ng2 vin vin) plv w=wp l=lp
m1 (n1 fb vtail 0) nlv w=wi l=li
m2 (ng vrefn vtail 0) nlv w=wi l=li
m3 (n1 n1 vin vin) plv w=wm l=lm
m4 (ng n1 vin vin) plv w=wm l=lm
mtail (vtail nb 0 0) nlv w=wt l=lt
mb (nb nb 0 0) nlv w=wb l=lb
Ibias (vin nb) isource dc=ib
Vrefs (vrefn 0) vsource dc=vref
R1 (vout fb) resistor r=r1
R2 (fb 0) resistor r=r2
Cout (vout ncesr) capacitor c=cout
Resr (ncesr 0) resistor r=resr
//  OTA-output node ng + fixed-pole RC into gate node ng2 that drives the pass
Cgate (ng 0) capacitor c=cg
Rgate (ng ng2) resistor r=rg
Cgate2 (ng2 0) capacitor c=cg2
ends ldo_pzmig
