// ---------------------------------------------------------------------------
// GENERATED by tools/gt_convert.py from ngspice/ldo_v3_miller.lib -- do not hand-edit.
// Synthetic ground-truth circuit; regenerate with `python tools/gt_convert.py`.
// ---------------------------------------------------------------------------
simulator lang=spectre
//  ============================================================
//  GT variant V3 -- TWO-STAGE MILLER-COMPENSATED LDO
//    Stresses: the single-resonance / 2-branch-RLC Zout assumption. A second
//              gain stage + Miller pole-split adds poles -> the Zout may show a
//              second peak or a different roll-off slope than (R+sL)||(ESR+1/sC).
//    Stage 1 = 5T OTA (output no1). Stage 2 = CS-NMOS gain stage w/ PMOS current
//    load, drives pass gate ng. Miller cap Cmil from ng to no1.
//  ============================================================
subckt ldo_v3_miller (vin vout)
parameters vref=0.6 wp=30e-6 lp=0.3e-6 wi=10e-6 li=0.5e-6 wm=10e-6 lm=0.5e-6 wt=20e-6 lt=0.5e-6 wb=20e-6 lb=0.5e-6 ib=10e-6 w2=20e-6 l2=0.5e-6 wl2=10e-6 ll2=0.5e-6 cm=15e-12 rz=300e3 r1=500e3 r2=1e6 cout=1e-9 resr=0.5 cg=0.3e-12

//  pass PMOS
mp (vout ng vin vin) plv w=wp l=lp

//  --- stage 1: 5T OTA, output no1.  m1 diode side gate=vrefn ; m2 out side gate=fb
//      (fb up -> no1 down -> ng up -> pass off -> vout down : negative feedback) ---
m1 (n1 vrefn vtail 0) nlv w=wi l=li
m2 (no1 fb vtail 0) nlv w=wi l=li
m3 (n1 n1 vin vin) plv w=wm l=lm
m4 (no1 n1 vin vin) plv w=wm l=lm
mtail (vtail nb 0 0) nlv w=wt l=lt
mb (nb nb 0 0) nlv w=wb l=lb
Ibias (vin nb) isource dc=ib
Vrefs (vrefn 0) vsource dc=vref

//  --- stage 2: common-source NMOS gain stage, PMOS current-source load -> ng ---
m2g (ng no1 0 0) nlv w=w2 l=l2
m2l (ng pbias vin vin) plv w=wl2 l=ll2
mpb (pbias pbias vin vin) plv w=wl2 l=ll2
Ipb (pbias 0) isource dc=ib

//  Miller compensation (pole split) ng -> no1, with nulling resistor
Rz (ng nz) resistor r=rz
Cmil (nz no1) capacitor c=cm

R1 (vout fb) resistor r=r1
R2 (fb 0) resistor r=r2
Cout (vout ncesr) capacitor c=cout
Resr (ncesr 0) resistor r=resr
Cgate (ng 0) capacitor c=cg
ends ldo_v3_miller
