// ---------------------------------------------------------------------------
// GENERATED by tools/gt_convert.py from ngspice/ldo_v6_spur2.lib -- do not hand-edit.
// Synthetic ground-truth circuit; regenerate with `python tools/gt_convert.py`.
// ---------------------------------------------------------------------------
simulator lang=spectre
//  ============================================================
//  Ground-truth LDO with TWO INCOMMENSURATE intrinsic spurs (multi-tone HB stress).
//    = ldo_gt + two deterministic tones at vout whose frequencies share no small
//      common base (1.0 MHz and 3.703125 MHz; bins 64 and 237, gcd=1 -> base would be
//      15.625kHz @ order 237 = effectively incommensurate). Forces the spur manifest
//      to declare TWO separate PSS/HB fundamentals rather than GCD-folding to one.
//    Both DC=0/AC=0 -> Zout/PSRR/noise/DC identical to base (pure additive overlay).
//  Requires models nlv / plv at top level.
//  ============================================================
subckt ldo_v6_spur2 (vin vout)
parameters vref=0.6 wp=30e-6 lp=0.3e-6 wi=10e-6 li=0.5e-6 wm=10e-6 lm=0.5e-6 wt=20e-6 lt=0.5e-6 wb=20e-6 lb=0.5e-6 ib=10e-6 r1=500e3 r2=1e6 cout=1e-9 resr=0.5 cg=1e-12 a1=5e-6 f1=1.0e6 a2=4e-6 f2=3.703125e6

mp (vout ng vin vin) plv w=wp l=lp
m1 (n1 fb vtail 0) nlv w=wi l=li
m2 (ng vrefn vtail 0) nlv w=wi l=li
m3 (n1 n1 vin vin) plv w=wm l=lm
m4 (ng n1 vin vin) plv w=wm l=lm
mtail (vtail nb 0 0) nlv w=wt l=lt
mb (nb nb 0 0) nlv w=wb l=lb
Ibias (vin nb) isource dc=ib
Vrefs (vrefn 0) vsource dc=vref
R1 (vout fb) resistor r=r1
R2 (fb 0) resistor r=r2
Cout (vout ncesr) capacitor c=cout
Resr (ncesr 0) resistor r=resr
Cgate (ng 0) capacitor c=cg

//  two incommensurate intrinsic tones straight at vout (Zout-shaped)
I1 (vout 0) isource dc=0 type=sine sinedc=0 ampl=a1 freq=f1
I2 (vout 0) isource dc=0 type=sine sinedc=0 ampl=a2 freq=f2
ends ldo_v6_spur2
