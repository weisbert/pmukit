// ---------------------------------------------------------------------------
// GENERATED by tools/gt_convert.py from ngspice/pmos_lv.mod -- do not hand-edit.
// Synthetic ground-truth circuit; regenerate with `python tools/gt_convert.py`.
// ---------------------------------------------------------------------------
simulator lang=spectre
//  Low-voltage PMOS BSIM3v3.3.0 (Berkeley default params, Vth0/Tox tuned for ~1.05V operation)
simulator lang=spice
.model plv pmos level=49 version=3.3 tnom=27.0 nch=3.533024E+17
+ tox=3.5E-09 xj=1.00000E-07 lint=6.23e-8 wint=1.22e-7 vth0=-0.30 k1=.8362093
+ k2=-8.606622E-02 k3=1.82 dvt0=1.903801 dvt1=.5333922 dvt2=-.1862677 nlx=1.28e-8
+ w0=2.1e-6 k3b=-0.24 prwg=-0.001 prwb=-0.323 vsat=103503.2 ua=1.39995E-09
+ ub=1.e-19 uc=-2.73e-11 rdsw=460 u0=138.7609 a0=.4716551 ags=0.12
+ keta=-1.871516E-03 a1=.3417965 a2=0.83 voff=-.074182 nfactor=1.54389 cit=-1.015667E-03
+ cdsc=8.937517E-04 cdscb=1.45e-4 cdscd=1.04e-4 dvt0w=0.232 dvt1w=4.5e6 dvt2w=-0.0023
+ eta0=6.024776E-02 etab=-4.64593E-03 dsub=.23222404 pclm=.989 pdiblc1=2.07418E-02 pdiblc2=1.33813E-3
+ drout=.3222404 pscbe1=118000 pscbe2=1E-09 pvag=0 kt1=-0.25 kt2=-0.032
+ prt=64.5 at=33000 ute=-1.5 ua1=4.312e-9 ub1=6.65e-19 uc1=0
+ kt1l=0 cgso=1.5e-10 cgdo=1.5e-10 cj=1e-3 cjsw=1e-10 noimod=1
+ kf=4e-29 af=1 ef=1
simulator lang=spectre
