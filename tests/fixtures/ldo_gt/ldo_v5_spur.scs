// ---------------------------------------------------------------------------
// GENERATED by tools/gt_convert.py from ngspice/ldo_v5_spur.lib -- do not hand-edit.
// Synthetic ground-truth circuit; regenerate with `python tools/gt_convert.py`.
// ---------------------------------------------------------------------------
simulator lang=spectre
//  ============================================================
//  Ground-truth LDO WITH INTRINSIC SPUR AGGRESSORS (Part B validation DUT)
//    ports: vin vout   (global 0 = gnd)
//    = ldo_gt (PMOS pass + 5T OTA) + deterministic on-chip spur sources, each
//      entering via a DIFFERENT internal path so they reach vout with different
//      loop/Zout shaping (exactly the situation the model must reproduce):
//        - reference spur : ripple on the internal Vref  (bandgap/chopper tone)
//        - bias spur      : current tone on the bias node (charge-pump ripple)
//        - output spur    : current tone straight at vout (clock feedthrough)
//    The model only sees vout, so all three manifest as discrete vout tones it
//    characterizes (transient-FFT) and re-injects. Small-signal Zout/PSRR/noise
//    are UNCHANGED vs base (tones are tiny + zero in DC/AC), so the spur block is
//    purely ADDITIVE on top of the base behavioral model.
//    Spur freqs sit on the 15.625kHz coherent grid (harness/spur_char.py window).
//  Requires models nlv / plv at top level.
//  ============================================================
subckt ldo_v5_spur (vin vout)
parameters vref=0.6 wp=30e-6 lp=0.3e-6 wi=10e-6 li=0.5e-6 wm=10e-6 lm=0.5e-6 wt=20e-6 lt=0.5e-6 wb=20e-6 lb=0.5e-6 ib=10e-6 r1=500e3 r2=1e6 cout=1e-9 resr=0.5 cg=1e-12 aref=200e-6 fref=1.0e6 acp=300e-9 fcp=2.5e6 aout=6e-6 fout=4.0e6

//  pass device (PMOS): source=vin gate=ng drain=vout bulk=vin
mp (vout ng vin vin) plv w=wp l=lp

//  5T OTA (NMOS input pair, PMOS mirror load)
m1 (n1 fb vtail 0) nlv w=wi l=li
m2 (ng vrefn vtail 0) nlv w=wi l=li
m3 (n1 n1 vin vin) plv w=wm l=lm
m4 (ng n1 vin vin) plv w=wm l=lm
mtail (vtail nb 0 0) nlv w=wt l=lt

//  tail current mirror bias
mb (nb nb 0 0) nlv w=wb l=lb
Ibias (vin nb) isource dc=ib

//  internal reference WITH a deterministic ripple spur (bandgap/chopper tone)
Vrefs (vrefn 0) vsource dc=vref type=sine sinedc=vref ampl=aref freq=fref

//  feedback divider
R1 (vout fb) resistor r=r1
R2 (fb 0) resistor r=r2

//  on-chip output cap + ESR
Cout (vout ncesr) capacitor c=cout
Resr (ncesr 0) resistor r=resr

//  gate-node cap
Cgate (ng 0) capacitor c=cg

//  ---- intrinsic spur aggressors (DC=0 -> no effect on DC/AC/.noise) ----
//  charge-pump ripple: current tone on the bias node (loop/bias-shaped to vout)
Icp (nb 0) isource dc=0 type=sine sinedc=0 ampl=acp freq=fcp
//  clock feedthrough: current tone straight at the output (Zout-shaped)
Iout (vout 0) isource dc=0 type=sine sinedc=0 ampl=aout freq=fout
ends ldo_v5_spur
